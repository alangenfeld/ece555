ADE simulation setup
Tests:
  ece555_final:multiplier_final_test:1: ece555_final/multiplier_final_test/layout, simulator hspiceD
