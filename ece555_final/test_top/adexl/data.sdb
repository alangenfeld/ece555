ADE simulation setup
Tests:
  ece555_final:test_top:1: ece555_final/test_top/extracted, simulator hspiceD
